ADE simulation setup
Test rxbb_virtuoso:rxBB_sim:1: rxbb_virtuoso/rxBB_sim/config_detailed, simulator ams
  Temperature: 27
  Analysis tran: stop=1.5m
  Output simple_Qout = getData("rxBB_sim.ISTIMULUS.Qout_int" ?result "tran")
  Output simple_Iout = getData("rxBB_sim.ISTIMULUS.Iout_int" ?result "tran")
  Signals: /outi<7:0>, /ISTIMULUS/outq<7:0> (terminal)
Test rxbb_virtuoso:rxBB_sim:2: rxbb_virtuoso/rxBB_sim/config, simulator ams
  Temperature: 27
  Analysis tran: stop=1.5m
  Output detailed_Qout = getData("rxBB_sim.ISTIMULUS.Qout_int" ?result "tran")
  Output detailed_Iout = getData("rxBB_sim.ISTIMULUS.Iout_int" ?result "tran")
  Signals: /outi<7:0>, /ISTIMULUS/outq<7:0> (terminal)
