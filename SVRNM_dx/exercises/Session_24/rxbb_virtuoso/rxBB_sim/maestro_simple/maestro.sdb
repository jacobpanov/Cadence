ADE simulation setup
Run mode: Single Run, Sweeps and Corners
Tests:
  rxbb_virtuoso:rxBB_sim:1: rxbb_virtuoso/rxBB_sim/config, simulator ams
