ADE simulation setup
Test rxbb_virtuoso:rxBB_sim:1: rxbb_virtuoso/rxBB_sim/config, simulator ams
  Temperature: 27
  Analysis tran: stop=1.5m
Run mode: Single Run, Sweeps and Corners
