ADE simulation setup
Test rxbb_virtuoso:rxBB_sim:1: rxbb_virtuoso/rxBB_sim/config, simulator ams
  Temperature: 27
  Analysis tran: stop=1.5m
  Signals: /inip, /inim, /inqp, /inqm, /adcRefEn, /outClkQ, /outq<7:0>, /outi<7:0>, /outClkI
Run mode: Single Run, Sweeps and Corners
