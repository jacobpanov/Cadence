// --- Begin Copyright Block -----[ do not move or remove ]------
// Copyright (c) 2019, Cadence Design Systems, Inc. All rights reserved.

// The model contained herein is the proprietary and confidential information
// of Cadence, and is supplied subject to, and may be used only by Cadences
// customer in accordance with a previously executed license and maintenance
// agreement between Cadence and that customer. This model is intended for use
// with products only from Cadence Design Systems, Inc.  The use or sharing of
// any models from this library or any of its modified/extended form is
// strictly prohibited with any non-Cadence products.

// ALL MATERIALS FURNISHED BY CADENCE HEREUNDER ARE PROVIDED "AS IS" WITHOUT
// WARRANTY OF ANY KIND, AND CADENCE SPECIFICALLY DISCLAIMS ANY WARRANTY OF
// NONINFRINGEMENT, FITNESS FOR A PARTICULAR PURPOSE OR MERCHANTABILITY.
// CADENCE SHALL NOT BE LIABLE FOR ANY COSTS OF PROCUREMENT OF SUBSTITUTES,
// LOSS OF PROFITS, INTERRUPTION OF BUSINESS, OR FOR ANY OTHER SPECIAL,
// CONSEQUENTIAL OR INCIDENTAL DAMAGES, HOWEVER CAUSED, WHETHER FOR BREACH OF
// WARRANTY, CONTRACT, TORT, NEGLIGENCE, STRICT LIABILITY OR OTHERWISE.
// --------------------------------------------------------------
//
// BASIC SINGLE POLE OPAMP MODEL
// Midstage defines inverting gain & offset, pole, and slewing.
// Output stage is just inverting buffer with specified output resistance.
// Input just sees a high differential resistance.
// No supply limiting included (pin vdd not yet used).
//
//     Updated:  2019-07-29 (ronv) Cadence Design Systems
// --------------------------------------------------------------

`include "constants.vams"
`include "disciplines.vams"

module opamp1 (output vout, input vinp,vinm, vdd,vss);
electrical vout, vinp,vinm, vdd,vss;

parameter real sr   = 100e6;    // slew rate (V/sec)
parameter real voff = 0;        // offset voltage (V)
parameter real ugf  = 10e6;     // unity gain freq (Hz)
parameter real av   = 10e3;     // DC gain (V/V)
parameter real rin  = 1e9;      // input resistance (ohms)
parameter real rout = 100;      // output resistance (ohms)
parameter real tinc = 0.16/ugf; // timestep size (sec) [FOR CLIP ONLY]
parameter real vtol = 0.1e-3;   // voltage tolerance (V) [NOT USED]

real gm1,c1,r1,imax,rclip,dv,iclip;

electrical N1;

// exponential current vs voltage function to provide voltage clipping:
//  V:  0   -dv    -K*dv    ... -30*dv
//  I:  i0  i0/e  i0/exp(K) ...    0
`define ilim(v,i0,dv)  ((v>-30*(dv))? i0*exp((v)/(dv)) : 0)

analog begin
  @(initial_step) begin            // initializations
    r1 = 1e6;
    c1 = 1/(`M_TWO_PI*r1*ugf/av);
    gm1 = av/r1;
    imax = c1*sr;
    rclip = tinc/(2000*c1);  // clipper uses 0.1% of EE cap Req
    dv = imax*rclip;
  end

  I(vinp,vinm) <+ V(vinp,vinm)/rin;          // input resistance

  I(N1) <+ -imax*tanh(gm1*V(vinp,vinm)/imax);// transcond & slew limiting
  I(N1) <+ V(N1)/r1;                         // resistor for DC gain
  I(N1) <+ ddt(c1*V(N1));                    // capacitor for pole
  iclip = `ilim(V(N1,vdd),imax,dv)-`ilim(-V(N1,vss),imax,dv); // clip current
  I(N1) <+ iclip;                            // current for voltage clipping
  I(vout,vss) <+ V(vout,N1)/rout;            // buffered output & resistance
end

endmodule
