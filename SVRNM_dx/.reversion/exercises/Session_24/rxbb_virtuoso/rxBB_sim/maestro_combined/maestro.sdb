ADE simulation setup
Run mode: Single Run, Sweeps and Corners
Tests:
  rxbb_virtuoso:rxBB_sim:1: rxbb_virtuoso/rxBB_sim/config_detailed, simulator ams
    Outputs: "/outi<7:0>"; ((rxBB_sim.ISTIMULUS).Qout_int)
  rxbb_virtuoso:rxBB_sim:2: rxbb_virtuoso/rxBB_sim/config, simulator ams
    Outputs: "/outi<7:0>"
