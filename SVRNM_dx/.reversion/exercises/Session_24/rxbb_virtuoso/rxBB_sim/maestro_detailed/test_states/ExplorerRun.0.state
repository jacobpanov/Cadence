ADE simulation setup
Test rxbb_virtuoso:rxBB_sim:1: rxbb_virtuoso/rxBB_sim/config_detailed, simulator ams
  Temperature: 27
  Analysis tran: stop=1.5m
