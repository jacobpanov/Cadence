// --- Begin Copyright Block -----[ do not move or remove ]------
// Copyright (c) 2018, Cadence Design Systems, Inc. All rights reserved.

// The model contained herein is the proprietary and confidential information
// of Cadence, and is supplied subject to, and may be used only by Cadences
// customer in accordance with a previously executed license and maintenance
// agreement between Cadence and that customer. This model is intended for use
// with products only from Cadence Design Systems, Inc.  The use or sharing of
// any models from this library or any of its modified/extended form is
// strictly prohibited with any non-Cadence products.

// ALL MATERIALS FURNISHED BY CADENCE HEREUNDER ARE PROVIDED "AS IS" WITHOUT
// WARRANTY OF ANY KIND, AND CADENCE SPECIFICALLY DISCLAIMS ANY WARRANTY OF
// NONINFRINGEMENT, FITNESS FOR A PARTICULAR PURPOSE OR MERCHANTABILITY.
// CADENCE SHALL NOT BE LIABLE FOR ANY COSTS OF PROCUREMENT OF SUBSTITUTES,
// LOSS OF PROFITS, INTERRUPTION OF BUSINESS, OR FOR ANY OTHER SPECIAL,
// CONSEQUENTIAL OR INCIDENTAL DAMAGES, HOWEVER CAUSED, WHETHER FOR BREACH OF
// WARRANTY, CONTRACT, TORT, NEGLIGENCE, STRICT LIABILITY OR OTHERWISE.
// --------------------------------------------------------------

// EVIRrampG.sv - driver for VIR format electrical signals including risetime

// General drive to electrical net - accepts all V/I/R combinations.
// Note that risetime and sample rate are specified in timescale units.
// A risetime of zero would mean that output changes immediately with input,
// which is mapped to risetime of "ttol" (ns) in this model (does not support
// zero delay that was available in discrete format of model).
// The sample step size control is ignored in this electrical model.

// RAMPING FORMATS:
//  V and I are both ramped linearly.
//  R is ramped logarithmically between 10 ohms and 10Mohms, with linear and
//  inverse tails on the ends to allow ramping to zero and infinite values
//  (or tiny and huge values) while spending only a minimal amount of the
//  ramp time outside of the 10 to 10M ohm region.
//  Model ramps variable "K" linearly between 0 and 8, and computes resistance
//  based on K value during ramp.  Here's a table showing the conversion format:
//      K:  0  0.01  0.1   1    2    3     4    5    6    7   7.9  7.99   8
//      R:  0   0.1   1   10   100  1000  1e4  1e5  1e6  1e7  1e8   1e9   Z
//    Type: |    linear    |       logarithmic            |    inverse    |
//  There will need to be several points within the ramp if you want to
//  accurately see the logarithmic ramping characteristic.
//  Large steps of resistance will typically be processed by capacitive elements
//  as if it were linearly ramping conductance over each step, so extra points
//  are important to accurately match analog response of switching operations.
//
//  Z state in this analog model is mapped to resistance "rz" parameter value.
//  When resistance is ramping from a low value up to Z, the voltage drive is
//  not changed (it stays at its previous value).  When resistance is ramping
//  back down from Z state to a lower value, the voltage change is performed
//  in the first 20% of the risetime of the resistance (while resistance is
//  very large).

// Note that when you interrupt a ramping waveform to ramp differently, the
// response of the analog "transition" function isn't the same as that used
// by VIRrampG.  In the discrete format, any change to V, I, or R while
// any change is in progress will replace the ramping effect of all
// currently ramping values to finish at the new Tr after the present time.
// In analog transition, only a new change to a ramping variable will cause
// it to ramp differently, using a risetime that's typically shorter than the
// specified risetime (see the VerilogAMS documentation for more detail of
// the transition function's operation).

// Updated:  2020-05-21 (ronv) Cadence Design Systems

`include "disciplines.vams"
`timescale 1ns/1ps

module EVIRrampG (P,vval,ival,rval,tr,ts);
inout P; electrical P;       // electrical net to drive
input wreal vval,ival,rval;  // input V,I,R values to drive to net
input wreal tr;              // (ns) risetime to the new (V,I,R) values
input wreal ts;              // max stepsize (UNUSED in electrical model)

parameter real ttol=0.01;    // (ns) time tolerance (minimum tr value)
parameter real rz=1e13;      // resistance used for Z input drive

real Vin,Kin;                // specified voltage and converted resistance
real Vdr,Idr,Kdr,Rdr;        // ramped V,I,K values and computed R

real Tr,Trv;                 // (seconds) output risetime and voltage risetime

// Functions to convert between resistance values and K values:
// (K value is ramped linearly, R value computed from K)
`define KtoR(K) ((K<=1)? 10*K : (K<7)? $exp(ln10*K) : (K<kz)? 1e7/((8-K)) : rz)
`define RtoK(R) ((R<=10)? 0.1*R : (R<1e7)? $ln(R)/ln10 : (R<rz)? 8-1e7/R : kz)

real ln10; initial ln10=$ln(10);  // constant (natural log of 10)
real kz;   initial kz=8-1e7/rz;   // rz value converted to K

always begin
  if (vval<1e9 && rval<rz) begin  // normal new V+R values
    Vin = vval;                   // pass V
    Trv = (Kin>=kz)? 0.2*Tr: Tr;  // rapid voltage transition when leaving Z
    Kin = `RtoK(rval);            // convert R to K
  end
  else  Kin = kz;                 // Going to X/Z just maps to output Z state
  @(vval,rval);
end

// Note that Tr=0 maps to minimum risetime here, similarly to VIRrampG's
// default of zero risetime, rather than VIRrampGs's default of sample time!
always begin
  if (tr>ttol) Tr=tr*1n;          // normal output risetime (in seconds)
  else         Tr=ttol*1n;        // if 0 or X, this model uses ttol.
  @(tr);
end

// Note that resistive ramping here only matches EEnet format for complete
// ramps:  interrupted transitions in VerilogAMS are processed differently.
analog begin
  Vdr = transition( Vin,  0, Trv,Trv,ttol*0.25n);
  Idr = transition( ival, 0, Tr, Tr, ttol*0.25n);
  Kdr = transition( Kin,  0, Tr, Tr, ttol*0.25n);
  Rdr = `KtoR(Kdr);
  if (Rdr<0.01)  V(P) <+ Vdr + (I(P)+Idr)*Rdr;   // near-ideal V source
  else           I(P) <+ (V(P)-Vdr)/Rdr - Idr;   // else normal V+R form
end

endmodule

`undef KtoR
`undef RtoK
