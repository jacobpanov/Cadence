// --- Begin Copyright Block -----[ do not move or remove ]------
// Copyright (c) 2019, Cadence Design Systems, Inc. All rights reserved.

// The model contained herein is the proprietary and confidential information
// of Cadence, and is supplied subject to, and may be used only by Cadences
// customer in accordance with a previously executed license and maintenance
// agreement between Cadence and that customer. This model is intended for use
// with products only from Cadence Design Systems, Inc.  The use or sharing of
// any models from this library or any of its modified/extended form is
// strictly prohibited with any non-Cadence products.

// ALL MATERIALS FURNISHED BY CADENCE HEREUNDER ARE PROVIDED "AS IS" WITHOUT
// WARRANTY OF ANY KIND, AND CADENCE SPECIFICALLY DISCLAIMS ANY WARRANTY OF
// NONINFRINGEMENT, FITNESS FOR A PARTICULAR PURPOSE OR MERCHANTABILITY.
// CADENCE SHALL NOT BE LIABLE FOR ANY COSTS OF PROCUREMENT OF SUBSTITUTES,
// LOSS OF PROFITS, INTERRUPTION OF BUSINESS, OR FOR ANY OTHER SPECIAL,
// CONSEQUENTIAL OR INCIDENTAL DAMAGES, HOWEVER CAUSED, WHETHER FOR BREACH OF
// WARRANTY, CONTRACT, TORT, NEGLIGENCE, STRICT LIABILITY OR OTHERWISE.
//--------------------------------------------------------------------------------------
//
// V-AMS submodule
//
//--------------------------------------------------------------------------------------
`timescale 1ns/1ps

`include "constants.vams"
`include "disciplines.vams"

module resVAMS (P, N, ires, Pint, Nint, rVal );

   parameter real Tsample = 100; //sample period in nsec

   inout P;
   inout N;
   electrical P;
   electrical N;
   output Pint;
   wreal Pint;
   output Nint;
   wreal Nint;
   output ires;  // +ive means into P pin
   wreal ires;
   input rVal;
   wreal rVal;

   real Pnow;
   real Nnow;
   real Preg;
   real Nreg;
   real iVal;
   real inow;

   analog begin
      Pnow = V(P);
      Nnow = V(N);
      inow = I(<P>);

      V(P,N) <+ I(P,N) * transition(rVal,0,1n);  // Resistance
   end

   // Sample terminal values to reflect to digital
   always #Tsample begin
      Preg = Pnow;
      Nreg = Nnow;
      iVal = inow;
   end

   assign Pint = Preg;
   assign Nint = Nreg;
   assign ires = iVal;
endmodule
