*
simulator lang=spectre

tran tran stop=1ms
