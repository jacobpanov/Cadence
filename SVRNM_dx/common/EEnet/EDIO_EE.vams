// --- Begin Copyright Block -----[ do not move or remove ]------
// Copyright (c) 2020, Cadence Design Systems, Inc. All rights reserved.

// The model contained herein is the proprietary and confidential information
// of Cadence, and is supplied subject to, and may be used only by Cadences
// customer in accordance with a previously executed license and maintenance
// agreement between Cadence and that customer. This model is intended for use
// with products only from Cadence Design Systems, Inc.  The use or sharing of
// any models from this library or any of its modified/extended form is
// strictly prohibited with any non-Cadence products.

// ALL MATERIALS FURNISHED BY CADENCE HEREUNDER ARE PROVIDED "AS IS" WITHOUT
// WARRANTY OF ANY KIND, AND CADENCE SPECIFICALLY DISCLAIMS ANY WARRANTY OF
// NONINFRINGEMENT, FITNESS FOR A PARTICULAR PURPOSE OR MERCHANTABILITY.
// CADENCE SHALL NOT BE LIABLE FOR ANY COSTS OF PROCUREMENT OF SUBSTITUTES,
// LOSS OF PROFITS, INTERRUPTION OF BUSINESS, OR FOR ANY OTHER SPECIAL,
// CONSEQUENTIAL OR INCIDENTAL DAMAGES, HOWEVER CAUSED, WHETHER FOR BREACH OF
// WARRANTY, CONTRACT, TORT, NEGLIGENCE, STRICT LIABILITY OR OTHERWISE.
// --------------------------------------------------------------
//
// EDIO_EE (A,C) - Electrical model of ideal diode
// Parameter von & ron define active operation; parameter roff in off mode.
// In "on" region:  Id = (V-von)/ron.
// In "off" region: Id = V/roff.
// For continuous analog model we define an exponential IvsV transition format,
// using a "dv" parameter to define exponential rate in the range from
// von-10dv up to von+1dv (assuming ron<<roff):
//   if     Vd>von+dv,   I = (Vd-von)/ron + Vd/roff
//   elseif Vd>von-10dv, I = (dv/ron)*exp(2.3*(Vd-von-dv)/dv) + Vd/roff
//   else                I = Vd/roff

// Simple two-state operation can cause iteration issues in analog simulation,
//  so this model includes option for parasitic cap across the diode (cp).

// Updated: 2020-05-26 (ronv)  added optional cp

`include "disciplines.vams"

module EDIO_EE (A,C);
  inout A,C; electrical A,C;  // diode anode and cathode pins

parameter real von=0.2;       // diode on voltage
parameter real ron=10;        // diode on resistance
parameter real roff=1e10;     // off resistance
parameter real dv=0.03;       // diode characteristic: dV per decade of current
parameter real cp=0;          // parasitic cap to improve convergence [F]
real Vh,Vl,Io;
initial begin
  Vh=von+dv;                  // crossing points between segments
  Vl=von-10*dv;
  Io=dv/ron;
end

real Rout;                    // computed output resistance
real Iana,Idio;               // measured current (analog & discrete variable)
branch (A,C) dio;             // branch across the diode
analog begin                  // analog drive:
  if (V(dio)>Vh)      I(dio) <+ (V(dio)-von)/ron + V(dio)/roff;
  else if (V(dio)>Vl) I(dio) <+ Io*limexp(2.3*(V(dio)-Vh)/dv) + V(dio)/roff;
  else                I(dio) <+ V(dio)/roff;
  if (cp>0) I(dio) <+ ddt(cp*V(dio));   // parasitic cap to help convergence
  Iana = I(dio);              // measure current through diode
end

// Move diode current value to discrete domain:
always @(absdelta(Iana,0)) Idio=Iana;

endmodule
