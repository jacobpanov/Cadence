// --- Begin Copyright Block -----[ do not move or remove ]------
// Copyright (c) 2020, Cadence Design Systems, Inc. All rights reserved.

// The model contained herein is the proprietary and confidential information
// of Cadence, and is supplied subject to, and may be used only by Cadences
// customer in accordance with a previously executed license and maintenance
// agreement between Cadence and that customer. This model is intended for use
// with products only from Cadence Design Systems, Inc.  The use or sharing of
// any models from this library or any of its modified/extended form is
// strictly prohibited with any non-Cadence products.

// ALL MATERIALS FURNISHED BY CADENCE HEREUNDER ARE PROVIDED "AS IS" WITHOUT
// WARRANTY OF ANY KIND, AND CADENCE SPECIFICALLY DISCLAIMS ANY WARRANTY OF
// NONINFRINGEMENT, FITNESS FOR A PARTICULAR PURPOSE OR MERCHANTABILITY.
// CADENCE SHALL NOT BE LIABLE FOR ANY COSTS OF PROCUREMENT OF SUBSTITUTES,
// LOSS OF PROFITS, INTERRUPTION OF BUSINESS, OR FOR ANY OTHER SPECIAL,
// CONSEQUENTIAL OR INCIDENTAL DAMAGES, HOWEVER CAUSED, WHETHER FOR BREACH OF
// WARRANTY, CONTRACT, TORT, NEGLIGENCE, STRICT LIABILITY OR OTHERWISE.
// --------------------------------------------------------------
//
// Electrical inductor model, including series resistance and initial condition
// Updated 5/26/2020 (ronv)

`include "disciplines.vams"

module  EIndD(P,N);
inout P,N; electrical P,N;  // differential pins to inductor

parameter real l=1e-9;      // inductance
parameter real rs=0;        // series resistance
parameter real ic=1e9;      // (A) uses DC op point for IC if not specified
real Vana,Iana,Iind;        // inductor analog V & I, and discrete form of I

analog begin
// inductor with specified initial current at DC:
  if (ic<1e9) I(P,N) <+ idt((V(P,N)-I(P,N)*rs)/l,ic); // integral form with IC
// inductor shorted at DC, with optional series resistance:
  else if (rs==0) I(P,N) <+ idt((V(P,N))/l);          // integral form, no IC
  else            V(P,N) <+ ddt(l*I(P,N))+rs*I(P,N);  // derivative form with RS
  Iana = I(P,N);                                      // measure current
end

// Move current value to discrete variable on each analog timestep:
always @(absdelta(Iana,0)) Iind = Iana;

endmodule
