// --- Begin Copyright Block -----[ do not move or remove ]------
// Copyright (c) 2018, Cadence Design Systems, Inc. All rights reserved.

// The model contained herein is the proprietary and confidential information
// of Cadence, and is supplied subject to, and may be used only by Cadences
// customer in accordance with a previously executed license and maintenance
// agreement between Cadence and that customer. This model is intended for use
// with products only from Cadence Design Systems, Inc.  The use or sharing of
// any models from this library or any of its modified/extended form is
// strictly prohibited with any non-Cadence products.

// ALL MATERIALS FURNISHED BY CADENCE HEREUNDER ARE PROVIDED "AS IS" WITHOUT
// WARRANTY OF ANY KIND, AND CADENCE SPECIFICALLY DISCLAIMS ANY WARRANTY OF
// NONINFRINGEMENT, FITNESS FOR A PARTICULAR PURPOSE OR MERCHANTABILITY.
// CADENCE SHALL NOT BE LIABLE FOR ANY COSTS OF PROCUREMENT OF SUBSTITUTES,
// LOSS OF PROFITS, INTERRUPTION OF BUSINESS, OR FOR ANY OTHER SPECIAL,
// CONSEQUENTIAL OR INCIDENTAL DAMAGES, HOWEVER CAUSED, WHETHER FOR BREACH OF
// WARRANTY, CONTRACT, TORT, NEGLIGENCE, STRICT LIABILITY OR OTHERWISE.
// --------------------------------------------------------------

// ECapG.vams - ELECTRICAL MODEL of single-ended capacitor from P to ground.

`timescale 1ns/1ps
`include "disciplines.vams"

module  ECapG(P);
inout P;
electrical P;

parameter real c=1e-9;     // capacitance
parameter real rs=0;       // series resistance
parameter real ic=1e9;     // initial voltage at time zero (or big uses DCOP)
parameter real tinc=1e-9;  // (NOT USED)
parameter real vtol=1e-4;  // (NOT USED)

real Vana,Iana,Vout,Icap;  // voltage & current for capacitor itself
real Vic = (ic<1e9)? ic:0; // make bounded version of initial condition value

analog begin
  Iana = I(P);             // measure current
  if (ic<1e9) Vana = idt(I(P)/c,Vic); // integrate to get cap voltage (with IC)
  else        Vana = idt(I(P)/c);     // or default does DC op with cap open
  V(P) <+ Vana + I(P)*rs;  // apply to pin, add series resistance term
end

// Move current value to discrete variable on each analog timestep:
always @(absdelta(Iana,0)) Icap = Iana;

endmodule
