// --- Begin Copyright Block -----[ do not move or remove ]------
// Copyright (c) 2020, Cadence Design Systems, Inc. All rights reserved.

// The model contained herein is the proprietary and confidential information
// of Cadence, and is supplied subject to, and may be used only by Cadences
// customer in accordance with a previously executed license and maintenance
// agreement between Cadence and that customer. This model is intended for use
// with products only from Cadence Design Systems, Inc.  The use or sharing of
// any models from this library or any of its modified/extended form is
// strictly prohibited with any non-Cadence products.

// ALL MATERIALS FURNISHED BY CADENCE HEREUNDER ARE PROVIDED "AS IS" WITHOUT
// WARRANTY OF ANY KIND, AND CADENCE SPECIFICALLY DISCLAIMS ANY WARRANTY OF
// NONINFRINGEMENT, FITNESS FOR A PARTICULAR PURPOSE OR MERCHANTABILITY.
// CADENCE SHALL NOT BE LIABLE FOR ANY COSTS OF PROCUREMENT OF SUBSTITUTES,
// LOSS OF PROFITS, INTERRUPTION OF BUSINESS, OR FOR ANY OTHER SPECIAL,
// CONSEQUENTIAL OR INCIDENTAL DAMAGES, HOWEVER CAUSED, WHETHER FOR BREACH OF
// WARRANTY, CONTRACT, TORT, NEGLIGENCE, STRICT LIABILITY OR OTHERWISE.
// --------------------------------------------------------------
//
// ClipG - clip EEnet net to specified supply limits.
//   VDD,VSS are supply inputs (real variables)
//   ron is on resistance of limiter
//   dV is distance from the supply to theshold point of limiter
//   Isat is current needed to get output to voltage limit (sets dV=Isat*ron)
// This electrical format matches the specified I&R at supply threshold,
// but extends in both directions with exponential relation to provide
// proper continuity for easier analog convergence.  No currents are generated
// in the supply pins - they are only used for voltage references.

// Updated 2019-07-29 (ronv) Cadence Design Systems

`include "disciplines.vams"

module EClipG (P,VDD,VSS);
  output P;             // electrical net (driven when clipping occuring)
  input VDD,VSS;        // electrical nets to define voltage levels to clip at
  electrical P,VDD,VSS;

parameter real ron=0.1;       // (ohm) on resistance at clip limit
parameter real isat=0.01;     // (A) current needed to drive to voltage limit
parameter real dv=ron*isat;   // (V) distance from supply to limiting threshold
parameter real itermax=20;    //  [EEnet control - not used]

// Exponential current vs voltage function:
//  V:  0   -dv    -K*dv    ... -30*dv
//  I:  i0  i0/e  i0/exp(K) ...    0
`define ilim(v,i0,dv)  ((v>-30*(dv))? i0*exp((v)/(dv)) : 0)

analog begin
  I(P) <+ `ilim(V(P,VDD),isat,dv) - `ilim(-V(P,VSS),isat,dv);
end

endmodule
